** Profile: "SCHEMATIC1-a"  [ D:\backep c\Uni\Term e 4\Electric Circuits\HW\8\orc\2-SCHEMATIC1-a.sim ]

** Creating circuit file "2-SCHEMATIC1-a.sim.cir"
** WARNING: THIS AUTOMATICALLY GENERATED FILE MAY BE OVERWRITTEN BY SUBSEQUENT SIMULATIONS

*Libraries:
* Local Libraries :
* From [PSPICE NETLIST] section of C:\Orcad\PSpice\PSpice.ini file:
.lib "nom.lib"

*Analysis directives:
.TRAN  0 10s 0
.PROBE V(*) I(*) W(*) D(*) NOISE(*)
.INC ".\2-SCHEMATIC1.net"

.END
